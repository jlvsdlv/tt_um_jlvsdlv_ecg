* NGSPICE file created from tt_um_jlvsdlv_ecg.ext - technology: sky130A

.subckt tt_um_jlvsdlv_ecg_C30 C1 C2
X0 C1 C2 sky130_fd_pr__cap_mim_m3_1 l=30 w=30
.ends

.subckt tt_um_jlvsdlv_ecg_P1L05 G D B S
X0 S G D B sky130_fd_pr__pfet_01v8 ad=0.29 pd=2.58 as=0.29 ps=2.58 w=1 l=0.5
.ends

.subckt tt_um_jlvsdlv_ecg_C122 C1 C2
X0 C1 C2 sky130_fd_pr__cap_mim_m3_1 l=12.2 w=12.2
.ends

.subckt tt_um_jlvsdlv_ecg_N2L05 G D B S
X0 S G D B sky130_fd_pr__nfet_01v8 ad=0.58 pd=4.58 as=0.58 ps=4.58 w=2 l=0.5
.ends

.subckt tt_um_jlvsdlv_ecg_MLAD G D B S
X0 S G D B sky130_fd_pr__pfet_01v8_lvt ad=0.58 pd=4.58 as=0.58 ps=4.58 w=2 l=2
.ends

.subckt tt_um_jlvsdlv_ecg_C173 C1 C2
X0 C1 C2 sky130_fd_pr__cap_mim_m3_1 l=17.3 w=17.3
.ends

.subckt tt_um_jlvsdlv_ecg_C245 C1 C2
X0 C1 C2 sky130_fd_pr__cap_mim_m3_1 l=24.5 w=24.5
.ends

.subckt tt_um_jlvsdlv_ecg_P4L05 G D B S
X0 S G D B sky130_fd_pr__pfet_01v8 ad=1.16 pd=8.58 as=1.16 ps=8.58 w=4 l=0.5
.ends

.subckt tt_um_jlvsdlv_ecg_MRB G D B S
X0 S G D B sky130_fd_pr__pfet_01v8 ad=0.58 pd=4.58 as=0.58 ps=4.58 w=2 l=20
.ends

.subckt tt_um_jlvsdlv_ecg_XP1 G B D2 D0 a_3287_n2536# S3 S1
X0 D2 G S1 B sky130_fd_pr__pfet_01v8_lvt ad=3.625 pd=25.29 as=3.625 ps=25.29 w=25 l=8
X1 S1 G D0 B sky130_fd_pr__pfet_01v8_lvt ad=3.625 pd=25.29 as=7.25 ps=50.58 w=25 l=8
X2 S3 G D2 B sky130_fd_pr__pfet_01v8_lvt ad=3.625 pd=25.29 as=3.625 ps=25.29 w=25 l=8
X3 a_3287_n2536# G S3 B sky130_fd_pr__pfet_01v8_lvt ad=7.25 pd=50.58 as=3.625 ps=25.29 w=25 l=8
.ends

.subckt tt_um_jlvsdlv_ecg_P042L4 G D B S
X0 S G D B sky130_fd_pr__pfet_01v8 ad=0.1218 pd=1.42 as=0.1218 ps=1.42 w=0.42 l=4
.ends

.subckt tt_um_jlvsdlv_ecg_MB2Q S49 D44 D32 S27 D22 S17 D10 D42 S37 D20 S15 G S47 D30
+ S25 D40 S35 S13 S45 S23 S33 S11 B S43 S21 S41 S31 D8 D6 D4 D2 D0 S9 S7 D18 D28 S5
+ D38 D16 a_11421_n236# D48 D26 S3 D36 D14 D46 D24 S19 S1 S39 D34 S29 D12
X0 S25 G D24 B sky130_fd_pr__pfet_01v8_lvt ad=0.29 pd=2.29 as=0.29 ps=2.29 w=2 l=2
X1 D28 G S27 B sky130_fd_pr__pfet_01v8_lvt ad=0.29 pd=2.29 as=0.29 ps=2.29 w=2 l=2
X2 S13 G D12 B sky130_fd_pr__pfet_01v8_lvt ad=0.29 pd=2.29 as=0.29 ps=2.29 w=2 l=2
X3 S47 G D46 B sky130_fd_pr__pfet_01v8_lvt ad=0.29 pd=2.29 as=0.29 ps=2.29 w=2 l=2
X4 D20 G S19 B sky130_fd_pr__pfet_01v8_lvt ad=0.29 pd=2.29 as=0.29 ps=2.29 w=2 l=2
X5 S3 G D2 B sky130_fd_pr__pfet_01v8_lvt ad=0.29 pd=2.29 as=0.29 ps=2.29 w=2 l=2
X6 D12 G S11 B sky130_fd_pr__pfet_01v8_lvt ad=0.29 pd=2.29 as=0.29 ps=2.29 w=2 l=2
X7 D34 G S33 B sky130_fd_pr__pfet_01v8_lvt ad=0.29 pd=2.29 as=0.29 ps=2.29 w=2 l=2
X8 S19 G D18 B sky130_fd_pr__pfet_01v8_lvt ad=0.29 pd=2.29 as=0.29 ps=2.29 w=2 l=2
X9 S43 G D42 B sky130_fd_pr__pfet_01v8_lvt ad=0.29 pd=2.29 as=0.29 ps=2.29 w=2 l=2
X10 D36 G S35 B sky130_fd_pr__pfet_01v8_lvt ad=0.29 pd=2.29 as=0.29 ps=2.29 w=2 l=2
X11 D16 G S15 B sky130_fd_pr__pfet_01v8_lvt ad=0.29 pd=2.29 as=0.29 ps=2.29 w=2 l=2
X12 D30 G S29 B sky130_fd_pr__pfet_01v8_lvt ad=0.29 pd=2.29 as=0.29 ps=2.29 w=2 l=2
X13 D44 G S43 B sky130_fd_pr__pfet_01v8_lvt ad=0.29 pd=2.29 as=0.29 ps=2.29 w=2 l=2
X14 S23 G D22 B sky130_fd_pr__pfet_01v8_lvt ad=0.29 pd=2.29 as=0.29 ps=2.29 w=2 l=2
X15 S37 G D36 B sky130_fd_pr__pfet_01v8_lvt ad=0.29 pd=2.29 as=0.29 ps=2.29 w=2 l=2
X16 a_11421_n236# G S49 B sky130_fd_pr__pfet_01v8_lvt ad=0.58 pd=4.58 as=0.29 ps=2.29 w=2 l=2
X17 D6 G S5 B sky130_fd_pr__pfet_01v8_lvt ad=0.29 pd=2.29 as=0.29 ps=2.29 w=2 l=2
X18 D40 G S39 B sky130_fd_pr__pfet_01v8_lvt ad=0.29 pd=2.29 as=0.29 ps=2.29 w=2 l=2
X19 S33 G D32 B sky130_fd_pr__pfet_01v8_lvt ad=0.29 pd=2.29 as=0.29 ps=2.29 w=2 l=2
X20 D10 G S9 B sky130_fd_pr__pfet_01v8_lvt ad=0.29 pd=2.29 as=0.29 ps=2.29 w=2 l=2
X21 D26 G S25 B sky130_fd_pr__pfet_01v8_lvt ad=0.29 pd=2.29 as=0.29 ps=2.29 w=2 l=2
X22 S49 G D48 B sky130_fd_pr__pfet_01v8_lvt ad=0.29 pd=2.29 as=0.29 ps=2.29 w=2 l=2
X23 S29 G D28 B sky130_fd_pr__pfet_01v8_lvt ad=0.29 pd=2.29 as=0.29 ps=2.29 w=2 l=2
X24 S7 G D6 B sky130_fd_pr__pfet_01v8_lvt ad=0.29 pd=2.29 as=0.29 ps=2.29 w=2 l=2
X25 S39 G D38 B sky130_fd_pr__pfet_01v8_lvt ad=0.29 pd=2.29 as=0.29 ps=2.29 w=2 l=2
X26 D14 G S13 B sky130_fd_pr__pfet_01v8_lvt ad=0.29 pd=2.29 as=0.29 ps=2.29 w=2 l=2
X27 S27 G D26 B sky130_fd_pr__pfet_01v8_lvt ad=0.29 pd=2.29 as=0.29 ps=2.29 w=2 l=2
X28 D32 G S31 B sky130_fd_pr__pfet_01v8_lvt ad=0.29 pd=2.29 as=0.29 ps=2.29 w=2 l=2
X29 D46 G S45 B sky130_fd_pr__pfet_01v8_lvt ad=0.29 pd=2.29 as=0.29 ps=2.29 w=2 l=2
X30 D4 G S3 B sky130_fd_pr__pfet_01v8_lvt ad=0.29 pd=2.29 as=0.29 ps=2.29 w=2 l=2
X31 S11 G D10 B sky130_fd_pr__pfet_01v8_lvt ad=0.29 pd=2.29 as=0.29 ps=2.29 w=2 l=2
X32 D18 G S17 B sky130_fd_pr__pfet_01v8_lvt ad=0.29 pd=2.29 as=0.29 ps=2.29 w=2 l=2
X33 D42 G S41 B sky130_fd_pr__pfet_01v8_lvt ad=0.29 pd=2.29 as=0.29 ps=2.29 w=2 l=2
X34 D48 G S47 B sky130_fd_pr__pfet_01v8_lvt ad=0.29 pd=2.29 as=0.29 ps=2.29 w=2 l=2
X35 S1 G D0 B sky130_fd_pr__pfet_01v8_lvt ad=0.29 pd=2.29 as=0.58 ps=4.58 w=2 l=2
X36 S17 G D16 B sky130_fd_pr__pfet_01v8_lvt ad=0.29 pd=2.29 as=0.29 ps=2.29 w=2 l=2
X37 D24 G S23 B sky130_fd_pr__pfet_01v8_lvt ad=0.29 pd=2.29 as=0.29 ps=2.29 w=2 l=2
X38 S45 G D44 B sky130_fd_pr__pfet_01v8_lvt ad=0.29 pd=2.29 as=0.29 ps=2.29 w=2 l=2
X39 D8 G S7 B sky130_fd_pr__pfet_01v8_lvt ad=0.29 pd=2.29 as=0.29 ps=2.29 w=2 l=2
X40 D22 G S21 B sky130_fd_pr__pfet_01v8_lvt ad=0.29 pd=2.29 as=0.29 ps=2.29 w=2 l=2
X41 D38 G S37 B sky130_fd_pr__pfet_01v8_lvt ad=0.29 pd=2.29 as=0.29 ps=2.29 w=2 l=2
X42 S5 G D4 B sky130_fd_pr__pfet_01v8_lvt ad=0.29 pd=2.29 as=0.29 ps=2.29 w=2 l=2
X43 S15 G D14 B sky130_fd_pr__pfet_01v8_lvt ad=0.29 pd=2.29 as=0.29 ps=2.29 w=2 l=2
X44 S31 G D30 B sky130_fd_pr__pfet_01v8_lvt ad=0.29 pd=2.29 as=0.29 ps=2.29 w=2 l=2
X45 S41 G D40 B sky130_fd_pr__pfet_01v8_lvt ad=0.29 pd=2.29 as=0.29 ps=2.29 w=2 l=2
X46 S21 G D20 B sky130_fd_pr__pfet_01v8_lvt ad=0.29 pd=2.29 as=0.29 ps=2.29 w=2 l=2
X47 D2 G S1 B sky130_fd_pr__pfet_01v8_lvt ad=0.29 pd=2.29 as=0.29 ps=2.29 w=2 l=2
X48 S9 G D8 B sky130_fd_pr__pfet_01v8_lvt ad=0.29 pd=2.29 as=0.29 ps=2.29 w=2 l=2
X49 S35 G D34 B sky130_fd_pr__pfet_01v8_lvt ad=0.29 pd=2.29 as=0.29 ps=2.29 w=2 l=2
.ends

.subckt tt_um_jlvsdlv_ecg_NL042L1 G D B S
X0 S G D B sky130_fd_pr__nfet_01v8_lvt ad=0.1218 pd=1.42 as=0.1218 ps=1.42 w=0.42 l=1
.ends

.subckt tt_um_jlvsdlv_ecg_NL2L8x4 G a_3287_n231# B D2 D0 S3 S1
X0 a_3287_n231# G S3 B sky130_fd_pr__nfet_01v8_lvt ad=0.58 pd=4.58 as=0.29 ps=2.29 w=2 l=8
X1 S1 G D0 B sky130_fd_pr__nfet_01v8_lvt ad=0.29 pd=2.29 as=0.58 ps=4.58 w=2 l=8
X2 D2 G S1 B sky130_fd_pr__nfet_01v8_lvt ad=0.29 pd=2.29 as=0.29 ps=2.29 w=2 l=8
X3 S3 G D2 B sky130_fd_pr__nfet_01v8_lvt ad=0.29 pd=2.29 as=0.29 ps=2.29 w=2 l=8
.ends

.subckt tt_um_jlvsdlv_ecg_NL2L8 G D B S
X0 S G D B sky130_fd_pr__nfet_01v8_lvt ad=0.58 pd=4.58 as=0.58 ps=4.58 w=2 l=8
.ends

.subckt tt_um_jlvsdlv_ecg_VAR9G a_n9280_n1088# a_n800_n1088# a_7680_n1088# w_5427_n1091#
+ w_n7293_n1091# w_n9413_n1091# a_1320_n1088# a_n5040_n1088# w_7547_n1091# w_n933_n1091#
+ a_3440_n1088# w_n3053_n1091# a_n7160_n1088# w_1187_n1091# w_3307_n1091# w_n5173_n1091#
+ a_5560_n1088# a_n2920_n1088# VSUBS
X0 a_7680_n1088# w_7547_n1091# VSUBS sky130_fd_pr__cap_var_lvt w=10 l=8
X1 a_3440_n1088# w_3307_n1091# VSUBS sky130_fd_pr__cap_var_lvt w=10 l=8
X2 a_5560_n1088# w_5427_n1091# VSUBS sky130_fd_pr__cap_var_lvt w=10 l=8
X3 a_n800_n1088# w_n933_n1091# VSUBS sky130_fd_pr__cap_var_lvt w=10 l=8
X4 a_1320_n1088# w_1187_n1091# VSUBS sky130_fd_pr__cap_var_lvt w=10 l=8
X5 a_n2920_n1088# w_n3053_n1091# VSUBS sky130_fd_pr__cap_var_lvt w=10 l=8
X6 a_n9280_n1088# w_n9413_n1091# VSUBS sky130_fd_pr__cap_var_lvt w=10 l=8
X7 a_n7160_n1088# w_n7293_n1091# VSUBS sky130_fd_pr__cap_var_lvt w=10 l=8
X8 a_n5040_n1088# w_n5173_n1091# VSUBS sky130_fd_pr__cap_var_lvt w=10 l=8
.ends

.subckt tt_um_jlvsdlv_ecg_XP1B G B D2 a_3287_n2464# D0 S3 S1
X0 S1 G D0 B sky130_fd_pr__pfet_01v8_lvt ad=3.625 pd=25.29 as=7.25 ps=50.58 w=25 l=8
X1 S3 G D2 B sky130_fd_pr__pfet_01v8_lvt ad=3.625 pd=25.29 as=3.625 ps=25.29 w=25 l=8
X2 a_3287_n2464# G S3 B sky130_fd_pr__pfet_01v8_lvt ad=7.25 pd=50.58 as=3.625 ps=25.29 w=25 l=8
X3 D2 G S1 B sky130_fd_pr__pfet_01v8_lvt ad=3.625 pd=25.29 as=3.625 ps=25.29 w=25 l=8
.ends

.subckt tt_um_jlvsdlv_ecg_N042L1 G D B S
X0 S G D B sky130_fd_pr__nfet_01v8 ad=0.1218 pd=1.42 as=0.1218 ps=1.42 w=0.42 l=1
.ends

.subckt tt_um_jlvsdlv_ecg_M34S G D B S
X0 S G D B sky130_fd_pr__nfet_01v8_lvt ad=0.725 pd=5.58 as=0.725 ps=5.58 w=2.5 l=64
.ends

.subckt tt_um_jlvsdlv_ecg_N1L05 G D B S
X0 S G D B sky130_fd_pr__nfet_01v8 ad=0.29 pd=2.58 as=0.29 ps=2.58 w=1 l=0.5
.ends

.subckt tt_um_jlvsdlv_ecg_N05L05 G D B S
X0 S G D B sky130_fd_pr__nfet_01v8 ad=0.145 pd=1.58 as=0.145 ps=1.58 w=0.5 l=0.5
.ends

.subckt tt_um_jlvsdlv_ecg_PL4L2 G D B S
X0 S G D B sky130_fd_pr__pfet_01v8_lvt ad=1.16 pd=8.58 as=1.16 ps=8.58 w=4 l=2
.ends

.subckt tt_um_jlvsdlv_ecg_VB0G w_n213_n291# a_n80_n288# VSUBS
X0 a_n80_n288# w_n213_n291# VSUBS sky130_fd_pr__cap_var_lvt w=2 l=0.8
.ends

.subckt tt_um_jlvsdlv_ecg_MSWP G D B S
X0 S G D B sky130_fd_pr__pfet_01v8_lvt ad=0.1218 pd=1.42 as=0.1218 ps=1.42 w=0.42 l=0.5
.ends

.subckt tt_um_jlvsdlv_ecg_RXA R1_4 R1_3 R1_2 R1_15 R1_1 R1_0 R1_14 R1_13 B R1_12 R1_11
+ R1_10 R2_9 R2_8 R2_7 R2_6 R2_5 R2_4 R2_3 R2_2 R2_1 R2_0 R2_15 R2_14 R2_13 R2_12
+ R1_9 R2_11 R1_8 R2_10 R1_7 R1_6 R1_5
X0 R1_2 R2_2 B sky130_fd_pr__res_xhigh_po_0p35 l=70
X1 R1_3 R2_3 B sky130_fd_pr__res_xhigh_po_0p35 l=70
X2 R1_13 R2_13 B sky130_fd_pr__res_xhigh_po_0p35 l=70
X3 R1_9 R2_9 B sky130_fd_pr__res_xhigh_po_0p35 l=70
X4 R1_0 R2_0 B sky130_fd_pr__res_xhigh_po_0p35 l=70
X5 R1_15 R2_15 B sky130_fd_pr__res_xhigh_po_0p35 l=70
X6 R1_12 R2_12 B sky130_fd_pr__res_xhigh_po_0p35 l=70
X7 R1_7 R2_7 B sky130_fd_pr__res_xhigh_po_0p35 l=70
X8 R1_4 R2_4 B sky130_fd_pr__res_xhigh_po_0p35 l=70
X9 R1_14 R2_14 B sky130_fd_pr__res_xhigh_po_0p35 l=70
X10 R1_10 R2_10 B sky130_fd_pr__res_xhigh_po_0p35 l=70
X11 R1_11 R2_11 B sky130_fd_pr__res_xhigh_po_0p35 l=70
X12 R1_1 R2_1 B sky130_fd_pr__res_xhigh_po_0p35 l=70
X13 R1_5 R2_5 B sky130_fd_pr__res_xhigh_po_0p35 l=70
X14 R1_6 R2_6 B sky130_fd_pr__res_xhigh_po_0p35 l=70
X15 R1_8 R2_8 B sky130_fd_pr__res_xhigh_po_0p35 l=70
.ends

.subckt tt_um_jlvsdlv_ecg_VB1G a_260_n288# a_n420_n288# w_n553_n291# w_127_n291# VSUBS
X0 a_260_n288# w_127_n291# VSUBS sky130_fd_pr__cap_var_lvt w=2 l=0.8
X1 a_n420_n288# w_n553_n291# VSUBS sky130_fd_pr__cap_var_lvt w=2 l=0.8
.ends

.subckt tt_um_jlvsdlv_ecg_RXB R1_1 R1_0 B R2_1 R2_0
X0 R1_0 R2_0 B sky130_fd_pr__res_xhigh_po_0p35 l=65.5
X1 R1_1 R2_1 B sky130_fd_pr__res_xhigh_po_0p35 l=65.5
.ends

.subckt tt_um_jlvsdlv_ecg_VB2G a_260_n288# a_n420_n288# a_n1100_n288# a_940_n288#
+ w_n553_n291# w_127_n291# w_807_n291# w_n1233_n291# VSUBS
X0 a_n1100_n288# w_n1233_n291# VSUBS sky130_fd_pr__cap_var_lvt w=2 l=0.8
X1 a_940_n288# w_807_n291# VSUBS sky130_fd_pr__cap_var_lvt w=2 l=0.8
X2 a_260_n288# w_127_n291# VSUBS sky130_fd_pr__cap_var_lvt w=2 l=0.8
X3 a_n420_n288# w_n553_n291# VSUBS sky130_fd_pr__cap_var_lvt w=2 l=0.8
.ends

.subckt tt_um_jlvsdlv_ecg_RXC R1_3 R1_2 R1_1 R1_0 B R2_3 R2_2 R2_1 R2_0
X0 R1_3 R2_3 B sky130_fd_pr__res_xhigh_po_0p35 l=65.5
X1 R1_1 R2_1 B sky130_fd_pr__res_xhigh_po_0p35 l=65.5
X2 R1_0 R2_0 B sky130_fd_pr__res_xhigh_po_0p35 l=65.5
X3 R1_2 R2_2 B sky130_fd_pr__res_xhigh_po_0p35 l=65.5
.ends

.subckt tt_um_jlvsdlv_ecg_VB3G a_260_n288# a_n2460_n288# a_n420_n288# a_n1100_n288#
+ a_940_n288# a_n1780_n288# a_2300_n288# w_2167_n291# w_n553_n291# a_1620_n288# w_1487_n291#
+ w_127_n291# w_807_n291# w_n1233_n291# w_n2593_n291# w_n1913_n291# VSUBS
X0 a_n1100_n288# w_n1233_n291# VSUBS sky130_fd_pr__cap_var_lvt w=2 l=0.8
X1 a_940_n288# w_807_n291# VSUBS sky130_fd_pr__cap_var_lvt w=2 l=0.8
X2 a_n2460_n288# w_n2593_n291# VSUBS sky130_fd_pr__cap_var_lvt w=2 l=0.8
X3 a_260_n288# w_127_n291# VSUBS sky130_fd_pr__cap_var_lvt w=2 l=0.8
X4 a_2300_n288# w_2167_n291# VSUBS sky130_fd_pr__cap_var_lvt w=2 l=0.8
X5 a_n420_n288# w_n553_n291# VSUBS sky130_fd_pr__cap_var_lvt w=2 l=0.8
X6 a_n1780_n288# w_n1913_n291# VSUBS sky130_fd_pr__cap_var_lvt w=2 l=0.8
X7 a_1620_n288# w_1487_n291# VSUBS sky130_fd_pr__cap_var_lvt w=2 l=0.8
.ends

.subckt tt_um_jlvsdlv_ecg_PL4L8 G D B S
X0 S G D B sky130_fd_pr__pfet_01v8_lvt ad=1.16 pd=8.58 as=1.16 ps=8.58 w=4 l=8
.ends

.subckt tt_um_jlvsdlv_ecg_VB4G a_n320_n888# w_n453_n891# VSUBS
X0 a_n320_n888# w_n453_n891# VSUBS sky130_fd_pr__cap_var_lvt w=8 l=3.2
.ends

.subckt tt_um_jlvsdlv_ecg_VB5G w_n1033_n891# w_127_n891# a_n900_n888# a_260_n888#
+ VSUBS
X0 a_260_n888# w_127_n891# VSUBS sky130_fd_pr__cap_var_lvt w=8 l=3.2
X1 a_n900_n888# w_n1033_n891# VSUBS sky130_fd_pr__cap_var_lvt w=8 l=3.2
.ends

.subckt tt_um_jlvsdlv_ecg_C7 C1 C2
X0 C1 C2 sky130_fd_pr__cap_mim_m3_1 l=7 w=7
.ends

.subckt tt_um_jlvsdlv_ecg_MIRB G D B S
X0 S G D B sky130_fd_pr__nfet_01v8_lvt ad=0.1218 pd=1.42 as=0.1218 ps=1.42 w=0.42 l=16
.ends

.subckt tt_um_jlvsdlv_ecg_NL2L8x8 G B a_6603_n231# D6 D4 D2 D0 S7 S5 S3 S1
X0 D6 G S5 B sky130_fd_pr__nfet_01v8_lvt ad=0.29 pd=2.29 as=0.29 ps=2.29 w=2 l=8
X1 S3 G D2 B sky130_fd_pr__nfet_01v8_lvt ad=0.29 pd=2.29 as=0.29 ps=2.29 w=2 l=8
X2 S1 G D0 B sky130_fd_pr__nfet_01v8_lvt ad=0.29 pd=2.29 as=0.58 ps=4.58 w=2 l=8
X3 S7 G D6 B sky130_fd_pr__nfet_01v8_lvt ad=0.29 pd=2.29 as=0.29 ps=2.29 w=2 l=8
X4 a_6603_n231# G S7 B sky130_fd_pr__nfet_01v8_lvt ad=0.58 pd=4.58 as=0.29 ps=2.29 w=2 l=8
X5 D4 G S3 B sky130_fd_pr__nfet_01v8_lvt ad=0.29 pd=2.29 as=0.29 ps=2.29 w=2 l=8
X6 S5 G D4 B sky130_fd_pr__nfet_01v8_lvt ad=0.29 pd=2.29 as=0.29 ps=2.29 w=2 l=8
X7 D2 G S1 B sky130_fd_pr__nfet_01v8_lvt ad=0.29 pd=2.29 as=0.29 ps=2.29 w=2 l=8
.ends

.subckt tt_um_jlvsdlv_ecg_PL2L2 G D B S
X0 S G D B sky130_fd_pr__pfet_01v8_lvt ad=0.58 pd=4.58 as=0.58 ps=4.58 w=2 l=2
.ends

.subckt tt_um_jlvsdlv_ecg_MB1 G a_2261_n236# B D8 D6 D4 D2 D0 S9 S7 S5 S3 S1
X0 S5 G D4 B sky130_fd_pr__pfet_01v8_lvt ad=0.29 pd=2.29 as=0.29 ps=2.29 w=2 l=2
X1 D8 G S7 B sky130_fd_pr__pfet_01v8_lvt ad=0.29 pd=2.29 as=0.29 ps=2.29 w=2 l=2
X2 a_2261_n236# G S9 B sky130_fd_pr__pfet_01v8_lvt ad=0.58 pd=4.58 as=0.29 ps=2.29 w=2 l=2
X3 S3 G D2 B sky130_fd_pr__pfet_01v8_lvt ad=0.29 pd=2.29 as=0.29 ps=2.29 w=2 l=2
X4 D6 G S5 B sky130_fd_pr__pfet_01v8_lvt ad=0.29 pd=2.29 as=0.29 ps=2.29 w=2 l=2
X5 S9 G D8 B sky130_fd_pr__pfet_01v8_lvt ad=0.29 pd=2.29 as=0.29 ps=2.29 w=2 l=2
X6 S7 G D6 B sky130_fd_pr__pfet_01v8_lvt ad=0.29 pd=2.29 as=0.29 ps=2.29 w=2 l=2
X7 D4 G S3 B sky130_fd_pr__pfet_01v8_lvt ad=0.29 pd=2.29 as=0.29 ps=2.29 w=2 l=2
X8 D2 G S1 B sky130_fd_pr__pfet_01v8_lvt ad=0.29 pd=2.29 as=0.29 ps=2.29 w=2 l=2
X9 S1 G D0 B sky130_fd_pr__pfet_01v8_lvt ad=0.29 pd=2.29 as=0.58 ps=4.58 w=2 l=2
.ends

.subckt tt_um_jlvsdlv_ecg_NL2L8x5 G B D4 D2 D0 S4 S3 S1
X0 D2 G S1 B sky130_fd_pr__nfet_01v8_lvt ad=0.29 pd=2.29 as=0.29 ps=2.29 w=2 l=8
X1 S3 G D2 B sky130_fd_pr__nfet_01v8_lvt ad=0.29 pd=2.29 as=0.29 ps=2.29 w=2 l=8
X2 S4 G D4 B sky130_fd_pr__nfet_01v8_lvt ad=0.58 pd=4.58 as=0.29 ps=2.29 w=2 l=8
X3 S1 G D0 B sky130_fd_pr__nfet_01v8_lvt ad=0.29 pd=2.29 as=0.58 ps=4.58 w=2 l=8
X4 D4 G S3 B sky130_fd_pr__nfet_01v8_lvt ad=0.29 pd=2.29 as=0.29 ps=2.29 w=2 l=8
.ends

.subckt tt_um_jlvsdlv_ecg_P2L05 G D B S
X0 S G D B sky130_fd_pr__pfet_01v8 ad=0.58 pd=4.58 as=0.58 ps=4.58 w=2 l=0.5
.ends

.subckt tt_um_jlvsdlv_ecg_C2025 C1 C2
X0 C1 C2 sky130_fd_pr__cap_mim_m3_1 l=20.25 w=20.25
.ends

.subckt tt_um_jlvsdlv_ecg_NL2L4 G D B S
X0 S G D B sky130_fd_pr__nfet_01v8_lvt ad=0.58 pd=4.58 as=0.58 ps=4.58 w=2 l=4
.ends

.subckt tt_um_jlvsdlv_ecg_MREP D44 D32 S27 D22 S17 D10 D42 S37 D20 S15 G S47 D30 S25
+ D40 S35 S13 S45 S23 S33 S11 B S43 S21 S41 S31 D8 D6 D4 D2 D0 a_6163_n1036# S9 S7
+ D18 D28 S5 D38 D16 D26 S3 D36 D14 D46 D24 S19 S1 S39 D34 S29 D12
X0 D44 G S43 B sky130_fd_pr__pfet_01v8 ad=1.45 pd=10.29 as=1.45 ps=10.29 w=10 l=1
X1 S7 G D6 B sky130_fd_pr__pfet_01v8 ad=1.45 pd=10.29 as=1.45 ps=10.29 w=10 l=1
X2 S11 G D10 B sky130_fd_pr__pfet_01v8 ad=1.45 pd=10.29 as=1.45 ps=10.29 w=10 l=1
X3 D12 G S11 B sky130_fd_pr__pfet_01v8 ad=1.45 pd=10.29 as=1.45 ps=10.29 w=10 l=1
X4 S39 G D38 B sky130_fd_pr__pfet_01v8 ad=1.45 pd=10.29 as=1.45 ps=10.29 w=10 l=1
X5 D16 G S15 B sky130_fd_pr__pfet_01v8 ad=1.45 pd=10.29 as=1.45 ps=10.29 w=10 l=1
X6 S27 G D26 B sky130_fd_pr__pfet_01v8 ad=1.45 pd=10.29 as=1.45 ps=10.29 w=10 l=1
X7 D34 G S33 B sky130_fd_pr__pfet_01v8 ad=1.45 pd=10.29 as=1.45 ps=10.29 w=10 l=1
X8 S45 G D44 B sky130_fd_pr__pfet_01v8 ad=1.45 pd=10.29 as=1.45 ps=10.29 w=10 l=1
X9 S17 G D16 B sky130_fd_pr__pfet_01v8 ad=1.45 pd=10.29 as=1.45 ps=10.29 w=10 l=1
X10 S5 G D4 B sky130_fd_pr__pfet_01v8 ad=1.45 pd=10.29 as=1.45 ps=10.29 w=10 l=1
X11 S29 G D28 B sky130_fd_pr__pfet_01v8 ad=1.45 pd=10.29 as=1.45 ps=10.29 w=10 l=1
X12 D22 G S21 B sky130_fd_pr__pfet_01v8 ad=1.45 pd=10.29 as=1.45 ps=10.29 w=10 l=1
X13 S25 G D24 B sky130_fd_pr__pfet_01v8 ad=1.45 pd=10.29 as=1.45 ps=10.29 w=10 l=1
X14 D40 G S39 B sky130_fd_pr__pfet_01v8 ad=1.45 pd=10.29 as=1.45 ps=10.29 w=10 l=1
X15 D10 G S9 B sky130_fd_pr__pfet_01v8 ad=1.45 pd=10.29 as=1.45 ps=10.29 w=10 l=1
X16 D4 G S3 B sky130_fd_pr__pfet_01v8 ad=1.45 pd=10.29 as=1.45 ps=10.29 w=10 l=1
X17 S15 G D14 B sky130_fd_pr__pfet_01v8 ad=1.45 pd=10.29 as=1.45 ps=10.29 w=10 l=1
X18 D28 G S27 B sky130_fd_pr__pfet_01v8 ad=1.45 pd=10.29 as=1.45 ps=10.29 w=10 l=1
X19 D46 G S45 B sky130_fd_pr__pfet_01v8 ad=1.45 pd=10.29 as=1.45 ps=10.29 w=10 l=1
X20 S9 G D8 B sky130_fd_pr__pfet_01v8 ad=1.45 pd=10.29 as=1.45 ps=10.29 w=10 l=1
X21 D20 G S19 B sky130_fd_pr__pfet_01v8 ad=1.45 pd=10.29 as=1.45 ps=10.29 w=10 l=1
X22 S41 G D40 B sky130_fd_pr__pfet_01v8 ad=1.45 pd=10.29 as=1.45 ps=10.29 w=10 l=1
X23 S21 G D20 B sky130_fd_pr__pfet_01v8 ad=1.45 pd=10.29 as=1.45 ps=10.29 w=10 l=1
X24 D36 G S35 B sky130_fd_pr__pfet_01v8 ad=1.45 pd=10.29 as=1.45 ps=10.29 w=10 l=1
X25 S3 G D2 B sky130_fd_pr__pfet_01v8 ad=1.45 pd=10.29 as=1.45 ps=10.29 w=10 l=1
X26 S31 G D30 B sky130_fd_pr__pfet_01v8 ad=1.45 pd=10.29 as=1.45 ps=10.29 w=10 l=1
X27 S35 G D34 B sky130_fd_pr__pfet_01v8 ad=1.45 pd=10.29 as=1.45 ps=10.29 w=10 l=1
X28 a_6163_n1036# G S47 B sky130_fd_pr__pfet_01v8 ad=2.9 pd=20.58 as=1.45 ps=10.29 w=10 l=1
X29 S47 G D46 B sky130_fd_pr__pfet_01v8 ad=1.45 pd=10.29 as=1.45 ps=10.29 w=10 l=1
X30 D8 G S7 B sky130_fd_pr__pfet_01v8 ad=1.45 pd=10.29 as=1.45 ps=10.29 w=10 l=1
X31 D30 G S29 B sky130_fd_pr__pfet_01v8 ad=1.45 pd=10.29 as=1.45 ps=10.29 w=10 l=1
X32 S43 G D42 B sky130_fd_pr__pfet_01v8 ad=1.45 pd=10.29 as=1.45 ps=10.29 w=10 l=1
X33 D38 G S37 B sky130_fd_pr__pfet_01v8 ad=1.45 pd=10.29 as=1.45 ps=10.29 w=10 l=1
X34 D42 G S41 B sky130_fd_pr__pfet_01v8 ad=1.45 pd=10.29 as=1.45 ps=10.29 w=10 l=1
X35 S13 G D12 B sky130_fd_pr__pfet_01v8 ad=1.45 pd=10.29 as=1.45 ps=10.29 w=10 l=1
X36 D26 G S25 B sky130_fd_pr__pfet_01v8 ad=1.45 pd=10.29 as=1.45 ps=10.29 w=10 l=1
X37 S1 G D0 B sky130_fd_pr__pfet_01v8 ad=1.45 pd=10.29 as=2.9 ps=20.58 w=10 l=1
X38 S33 G D32 B sky130_fd_pr__pfet_01v8 ad=1.45 pd=10.29 as=1.45 ps=10.29 w=10 l=1
X39 S37 G D36 B sky130_fd_pr__pfet_01v8 ad=1.45 pd=10.29 as=1.45 ps=10.29 w=10 l=1
X40 S23 G D22 B sky130_fd_pr__pfet_01v8 ad=1.45 pd=10.29 as=1.45 ps=10.29 w=10 l=1
X41 D14 G S13 B sky130_fd_pr__pfet_01v8 ad=1.45 pd=10.29 as=1.45 ps=10.29 w=10 l=1
X42 D18 G S17 B sky130_fd_pr__pfet_01v8 ad=1.45 pd=10.29 as=1.45 ps=10.29 w=10 l=1
X43 D24 G S23 B sky130_fd_pr__pfet_01v8 ad=1.45 pd=10.29 as=1.45 ps=10.29 w=10 l=1
X44 D2 G S1 B sky130_fd_pr__pfet_01v8 ad=1.45 pd=10.29 as=1.45 ps=10.29 w=10 l=1
X45 D6 G S5 B sky130_fd_pr__pfet_01v8 ad=1.45 pd=10.29 as=1.45 ps=10.29 w=10 l=1
X46 S19 G D18 B sky130_fd_pr__pfet_01v8 ad=1.45 pd=10.29 as=1.45 ps=10.29 w=10 l=1
X47 D32 G S31 B sky130_fd_pr__pfet_01v8 ad=1.45 pd=10.29 as=1.45 ps=10.29 w=10 l=1
.ends

.subckt tt_um_jlvsdlv_ecg_C236 C1 C2
X0 C1 C2 sky130_fd_pr__cap_mim_m3_1 l=23.6 w=23.6
.ends

.subckt tt_um_jlvsdlv_ecg clk ena rst_n ua[0] ua[1] ua[2] ua[3] ua[4] ua[5] ua[6]
+ ua[7] ui_in[0] ui_in[1] ui_in[2] ui_in[3] ui_in[4] ui_in[5] ui_in[6] ui_in[7] uio_in[0]
+ uio_in[1] uio_in[2] uio_in[3] uio_in[4] uio_in[5] uio_in[6] uio_in[7] VDPWR VGND
XXCG_7 XMR4/D XMR3/D tt_um_jlvsdlv_ecg_C30
XXIRSTP uio_in[3] XSWF4/G VDPWR VDPWR tt_um_jlvsdlv_ecg_P1L05
XXCT1_6 ua[0] XSCT1_6/D tt_um_jlvsdlv_ecg_C122
XXI2bN XI2bP/G XI2bP/D VGND VGND tt_um_jlvsdlv_ecg_N2L05
XXLD2 XLD3/S XLD3/S XLD2/S XLD2/S tt_um_jlvsdlv_ecg_MLAD
XXCT1_7 ua[0] XSCT1_7/D tt_um_jlvsdlv_ecg_C173
XXI2aN XI2aP/G XI2aP/D VGND VGND tt_um_jlvsdlv_ecg_N2L05
XXLD3 XLD4/S XLD4/S XLD3/S XLD3/S tt_um_jlvsdlv_ecg_MLAD
XXCT1_8 ua[0] XSCT1_8/D tt_um_jlvsdlv_ecg_C245
XXI2bP XI2bP/G XI2bP/D VDPWR VDPWR tt_um_jlvsdlv_ecg_P4L05
XXLD4 XLD5/S XLD5/S XLD4/S XLD4/S tt_um_jlvsdlv_ecg_MLAD
XXMRB20 XMREP/G XMRB21/S XA1/G XA1/G tt_um_jlvsdlv_ecg_MRB
XXI2aP XI2aP/G XI2aP/D VDPWR VDPWR tt_um_jlvsdlv_ecg_P4L05
XXLD5 XLD6/S XLD6/S XLD5/S XLD5/S tt_um_jlvsdlv_ecg_MLAD
XXM1_3U ua[0] XSWB1/D ua[3] ua[3] ua[3] XA1/G XA1/G tt_um_jlvsdlv_ecg_XP1
XXMR3 ua[3] XMR3/D ua[3] ua[3] tt_um_jlvsdlv_ecg_P042L4
XXMRB21 XMREP/G XMRB22/S XMRB21/S XMRB21/S tt_um_jlvsdlv_ecg_MRB
XXMRB10 XMREP/G XMRB11/S XA1/G XA1/G tt_um_jlvsdlv_ecg_MRB
XXMB2_0 ua[5] XA1/G XA1/G ua[5] XA1/G ua[5] XA1/G XA1/G ua[5] XA1/G ua[5] XBP/G ua[5]
+ XA1/G ua[5] XA1/G ua[5] ua[5] ua[5] ua[5] ua[5] ua[5] ua[5] ua[5] ua[5] ua[5] ua[5]
+ XA1/G XA1/G XA1/G XA1/G XA1/G ua[5] ua[5] XA1/G XA1/G ua[5] XA1/G XA1/G XA1/G XA1/G
+ XA1/G ua[5] XA1/G XA1/G XA1/G XA1/G ua[5] ua[5] ua[5] XA1/G ua[5] XA1/G tt_um_jlvsdlv_ecg_MB2Q
XXCBM1_0 XSWB1/D ua[0] tt_um_jlvsdlv_ecg_C30
XXM1_2U ua[0] XSWB1/D ua[3] ua[3] ua[3] XA1/G XA1/G tt_um_jlvsdlv_ecg_XP1
XXLD6 VGND VGND XLD6/S XLD6/S tt_um_jlvsdlv_ecg_MLAD
XXMR4 ua[2] XMR4/D ua[2] ua[2] tt_um_jlvsdlv_ecg_P042L4
XXMRB22 XMREP/G XMRB23/S XMRB22/S XMRB22/S tt_um_jlvsdlv_ecg_MRB
XXMRB11 XMREP/G XMRB12/S XMRB11/S XMRB11/S tt_um_jlvsdlv_ecg_MRB
XXRMI XRP1/D XRML/D VGND VGND tt_um_jlvsdlv_ecg_NL042L1
XXMB2_1 ua[5] XA1/G XA1/G ua[5] XA1/G ua[5] XA1/G XA1/G ua[5] XA1/G ua[5] XBP/G ua[5]
+ XA1/G ua[5] XA1/G ua[5] ua[5] ua[5] ua[5] ua[5] ua[5] ua[5] ua[5] ua[5] ua[5] ua[5]
+ XA1/G XA1/G XA1/G XA1/G XA1/G ua[5] ua[5] XA1/G XA1/G ua[5] XA1/G XA1/G XA1/G XA1/G
+ XA1/G ua[5] XA1/G XA1/G XA1/G XA1/G ua[5] ua[5] ua[5] XA1/G ua[5] XA1/G tt_um_jlvsdlv_ecg_MB2Q
XXCBM1_1 XSWB1/D ua[0] tt_um_jlvsdlv_ecg_C30
XXS2B XS2/G ua[4] VGND ua[4] ua[4] VGND VGND tt_um_jlvsdlv_ecg_NL2L8x4
XXM1_1U ua[0] XSWB1/D ua[3] ua[3] ua[3] XA1/G XA1/G tt_um_jlvsdlv_ecg_XP1
XXS1 XS2/G XS1/D VGND VGND tt_um_jlvsdlv_ecg_NL2L8
XXMRB23 XMREP/G XSWB2/D XMRB23/S XMRB23/S tt_um_jlvsdlv_ecg_MRB
XXMRB12 XMREP/G XMRB13/S XMRB12/S XMRB12/S tt_um_jlvsdlv_ecg_MRB
XXMB2_2 ua[5] XA1/G XA1/G ua[5] XA1/G ua[5] XA1/G XA1/G ua[5] XA1/G ua[5] XBP/G ua[5]
+ XA1/G ua[5] XA1/G ua[5] ua[5] ua[5] ua[5] ua[5] ua[5] ua[5] ua[5] ua[5] ua[5] ua[5]
+ XA1/G XA1/G XA1/G XA1/G XA1/G ua[5] ua[5] XA1/G XA1/G ua[5] XA1/G XA1/G XA1/G XA1/G
+ XA1/G ua[5] XA1/G XA1/G XA1/G XA1/G ua[5] ua[5] ua[5] XA1/G ua[5] XA1/G tt_um_jlvsdlv_ecg_MB2Q
XXCBM1_2 XSWB1/D ua[0] tt_um_jlvsdlv_ecg_C30
XXM1_0U ua[0] XSWB1/D ua[3] ua[3] ua[3] XA1/G XA1/G tt_um_jlvsdlv_ecg_XP1
XXCBC2_0 XSWB2/D XSWB2/D XSWB2/D ua[1] ua[1] ua[1] XSWB2/D XSWB2/D ua[1] ua[1] XSWB2/D
+ ua[1] XSWB2/D ua[1] ua[1] ua[1] XSWB2/D XSWB2/D VGND tt_um_jlvsdlv_ecg_VAR9G
XXM2_3L ua[1] XSWB2/D ua[2] ua[2] ua[2] XA1/G XA1/G tt_um_jlvsdlv_ecg_XP1B
XXS2 XS2/G ua[4] VGND ua[4] ua[4] VGND VGND tt_um_jlvsdlv_ecg_NL2L8x4
XXMRB13 XMREP/G XSWB1/D XMRB13/S XMRB13/S tt_um_jlvsdlv_ecg_MRB
XXRMK XRML/D XRP2/G VGND VGND tt_um_jlvsdlv_ecg_N042L1
XXMB2_3 ua[5] XA1/G XA1/G ua[5] XA1/G ua[5] XA1/G XA1/G ua[5] XA1/G ua[5] XBP/G ua[5]
+ XA1/G ua[5] XA1/G ua[5] ua[5] ua[5] ua[5] ua[5] ua[5] ua[5] ua[5] ua[5] ua[5] ua[5]
+ XA1/G XA1/G XA1/G XA1/G XA1/G ua[5] ua[5] XA1/G XA1/G ua[5] XA1/G XA1/G XA1/G XA1/G
+ XA1/G ua[5] XA1/G XA1/G XA1/G XA1/G ua[5] ua[5] ua[5] XA1/G ua[5] XA1/G tt_um_jlvsdlv_ecg_MB2Q
XXCBC2_1 XSWB2/D XSWB2/D XSWB2/D ua[1] ua[1] ua[1] XSWB2/D XSWB2/D ua[1] ua[1] XSWB2/D
+ ua[1] XSWB2/D ua[1] ua[1] ua[1] XSWB2/D XSWB2/D VGND tt_um_jlvsdlv_ecg_VAR9G
XXCBM1_3 XSWB1/D ua[0] tt_um_jlvsdlv_ecg_C30
XXM4A_0 XMR4/D ua[2] XMCLa/B VGND tt_um_jlvsdlv_ecg_M34S
XXM2_2L ua[1] XSWB2/D ua[2] ua[2] ua[2] XA1/G XA1/G tt_um_jlvsdlv_ecg_XP1B
XXRML ua[5] XRML/D ua[5] ua[5] tt_um_jlvsdlv_ecg_P042L4
XXM4A_1 XMR4/D ua[2] XMCLa/B VGND tt_um_jlvsdlv_ecg_M34S
XXCBM1_4 XSWB1/D ua[0] tt_um_jlvsdlv_ecg_C30
XXCBC2_2 XSWB2/D XSWB2/D XSWB2/D ua[1] ua[1] ua[1] XSWB2/D XSWB2/D ua[1] ua[1] XSWB2/D
+ ua[1] XSWB2/D ua[1] ua[1] ua[1] XSWB2/D XSWB2/D VGND tt_um_jlvsdlv_ecg_VAR9G
XXM2_1L ua[1] XSWB2/D ua[2] ua[2] ua[2] XA1/G XA1/G tt_um_jlvsdlv_ecg_XP1B
XXSCT1_0 ui_in[0] XSCT1_0/D VGND VGND tt_um_jlvsdlv_ecg_N1L05
XXMCLa VGND VGND XMCLa/B VGND tt_um_jlvsdlv_ecg_N2L05
XXIKCN clk XIKCP/D VGND VGND tt_um_jlvsdlv_ecg_N05L05
XXM2_0L ua[1] XSWB2/D ua[2] ua[2] ua[2] XA1/G XA1/G tt_um_jlvsdlv_ecg_XP1B
XXP2 XPB/D ua[4] ua[5] ua[5] tt_um_jlvsdlv_ecg_PL4L2
XXSCT1_1 ui_in[1] XSCT1_1/D VGND VGND tt_um_jlvsdlv_ecg_N1L05
XXMCLb VGND VGND XMCLb/B VGND tt_um_jlvsdlv_ecg_N2L05
XXCT2_0 XSCT2_0/D ua[1] VGND tt_um_jlvsdlv_ecg_VB0G
XXSWF3 XSWF4/G XMR3/D ua[3] ua[3] tt_um_jlvsdlv_ecg_MSWP
XXSCT1_2 ui_in[2] XSCT1_2/D VGND VGND tt_um_jlvsdlv_ecg_N1L05
XXRS1 uio_in[4] XRS1/D VGND XRS2/D tt_um_jlvsdlv_ecg_N1L05
XXRR0 XRR0/R1_4 XRR0/R1_4 XRR0/R1_2 XRS1/D XRR0/R1_2 XRN2/S7 XRR0/R1_14 XRR0/R1_14
+ VGND XRR0/R1_12 XRR0/R1_12 XRR0/R1_9 XRR0/R2_9 XRR0/R2_9 XRR0/R2_7 XRR0/R2_7 XRR0/R2_5
+ XRR0/R2_5 XRR0/R2_3 XRR0/R2_3 XRR0/R2_1 XRR0/R2_1 XRR0/R2_15 XRR0/R2_15 XRR0/R2_13
+ XRR0/R2_13 XRR0/R1_9 XRR0/R2_11 XRR0/R1_8 XRR0/R2_11 XRR0/R1_8 XRR0/R1_6 XRR0/R1_6
+ tt_um_jlvsdlv_ecg_RXA
XXM3B_0 XMR3/D ua[3] XMCLb/B VGND tt_um_jlvsdlv_ecg_M34S
XXIKCP clk XIKCP/D VDPWR VDPWR tt_um_jlvsdlv_ecg_P1L05
XXCT2_1 ua[1] ua[1] XSCT2_1/D XSCT2_1/D VGND tt_um_jlvsdlv_ecg_VB1G
XXSWF4 XSWF4/G XMR4/D ua[2] ua[2] tt_um_jlvsdlv_ecg_MSWP
XXSCT1_3 ui_in[3] XSCT1_3/D VGND VGND tt_um_jlvsdlv_ecg_N1L05
XXRS2 uio_in[5] XRS2/D VGND VGND tt_um_jlvsdlv_ecg_N1L05
XXRR1 XRS2/D XRS1/D VGND XRR1/R2_1 XRR1/R2_1 tt_um_jlvsdlv_ecg_RXB
XXM3B_1 XMR3/D ua[3] XMCLb/B VGND tt_um_jlvsdlv_ecg_M34S
XXCT2_2 ua[1] ua[1] ua[1] ua[1] XSCT2_2/D XSCT2_2/D XSCT2_2/D XSCT2_2/D VGND tt_um_jlvsdlv_ecg_VB2G
XXNDAaP1 clk XI1aP/G VDPWR VDPWR tt_um_jlvsdlv_ecg_P1L05
XXSWB1 XSWF4/G XSWB1/D XA1/G XA1/G tt_um_jlvsdlv_ecg_MSWP
XXCCA_0 XI2aP/D XMCLa/B tt_um_jlvsdlv_ecg_C30
XXSCT1_4 ui_in[4] XSCT1_4/D VGND VGND tt_um_jlvsdlv_ecg_N1L05
XXRR2 VGND XRR2/R1_2 XRR2/R1_2 XRS2/D VGND XRR2/R2_3 XRR2/R2_3 XRR2/R2_1 XRR2/R2_1
+ tt_um_jlvsdlv_ecg_RXC
XXNDAaP2 uio_in[2] XI1aP/G VDPWR VDPWR tt_um_jlvsdlv_ecg_P1L05
XXCT2_3 ua[1] ua[1] ua[1] ua[1] ua[1] ua[1] ua[1] XSCT2_3/D XSCT2_3/D ua[1] XSCT2_3/D
+ XSCT2_3/D XSCT2_3/D XSCT2_3/D XSCT2_3/D XSCT2_3/D VGND tt_um_jlvsdlv_ecg_VB3G
XXSWB2 XSWF4/G XSWB2/D XA1/G XA1/G tt_um_jlvsdlv_ecg_MSWP
XXSCT1_5 ui_in[5] XSCT1_5/D VGND VGND tt_um_jlvsdlv_ecg_N1L05
XXCCA_1 XI2aP/D XMCLa/B tt_um_jlvsdlv_ecg_C30
XXRP1 XRP2/G XRP1/D ua[5] ua[5] tt_um_jlvsdlv_ecg_PL4L8
XXCT2_4 ua[1] XSCT2_4/D VGND tt_um_jlvsdlv_ecg_VB4G
XXNDAaN1 clk XI1aP/G VGND XNDAaN2/D tt_um_jlvsdlv_ecg_N1L05
XXCCA_2 XI2aP/D XMCLa/B tt_um_jlvsdlv_ecg_C30
XXRP2 XRP2/G XRP2/G ua[5] ua[5] tt_um_jlvsdlv_ecg_PL4L8
XXSCT1_6 ui_in[6] XSCT1_6/D VGND VGND tt_um_jlvsdlv_ecg_N1L05
XXNDAaN2 uio_in[2] XNDAaN2/D VGND VGND tt_um_jlvsdlv_ecg_N1L05
XXM2_3U ua[1] XSWB2/D ua[2] ua[2] ua[2] XA1/G XA1/G tt_um_jlvsdlv_ecg_XP1
XXCT2_5 XSCT2_5/D XSCT2_5/D ua[1] ua[1] VGND tt_um_jlvsdlv_ecg_VB5G
XXCST ua[5] XRML/D tt_um_jlvsdlv_ecg_C7
XXBN XS2/G XS2/G VGND VGND tt_um_jlvsdlv_ecg_NL2L8
XXSCT1_7 ui_in[7] XSCT1_7/D VGND VGND tt_um_jlvsdlv_ecg_N1L05
XXRN1 XRP1/D XRP1/D VGND VGND tt_um_jlvsdlv_ecg_NL2L8
XXIRBM XS2/G XMREP/G VGND VGND tt_um_jlvsdlv_ecg_MIRB
XXCT2_6 ua[1] XSCT2_6/D tt_um_jlvsdlv_ecg_C122
XXCT1_9a ua[0] XSCT1_9/D tt_um_jlvsdlv_ecg_C245
XXM2_2U ua[1] XSWB2/D ua[2] ua[2] ua[2] XA1/G XA1/G tt_um_jlvsdlv_ecg_XP1
XXRN2 XRP1/D VGND XRP2/G XRP2/G XRP2/G XRP2/G XRP2/G XRN2/S7 XRN2/S7 XRN2/S7 XRN2/S7
+ tt_um_jlvsdlv_ecg_NL2L8x8
XXSCT1_8 uio_in[0] XSCT1_8/D VGND VGND tt_um_jlvsdlv_ecg_N1L05
XXCT1_9b ua[0] XSCT1_9/D tt_um_jlvsdlv_ecg_C245
XXM2_1U ua[1] XSWB2/D ua[2] ua[2] ua[2] XA1/G XA1/G tt_um_jlvsdlv_ecg_XP1
XXCT2_7 ua[1] XSCT2_7/D tt_um_jlvsdlv_ecg_C173
XXBP XBP/G XS2/G ua[5] ua[5] tt_um_jlvsdlv_ecg_PL2L2
XXSCT1_9 uio_in[1] XSCT1_9/D VGND VGND tt_um_jlvsdlv_ecg_N1L05
XXMB1 XBP/G XBP/G ua[5] XBP/G XBP/G XBP/G XBP/G XBP/G ua[5] ua[5] ua[5] ua[5] ua[5]
+ tt_um_jlvsdlv_ecg_MB1
XXRN3 XRP1/D VGND XBP/G XBP/G XBP/G VGND VGND VGND tt_um_jlvsdlv_ecg_NL2L8x5
XXCT2_8 ua[1] XSCT2_8/D tt_um_jlvsdlv_ecg_C245
XXM2_0U ua[1] XSWB2/D ua[2] ua[2] ua[2] XA1/G XA1/G tt_um_jlvsdlv_ecg_XP1
XXI1bN XI1bP/G XI2bP/G VGND VGND tt_um_jlvsdlv_ecg_N1L05
XXCBM2_0 XSWB2/D ua[1] tt_um_jlvsdlv_ecg_C30
XXI1aN XI1aP/G XI2aP/G VGND VGND tt_um_jlvsdlv_ecg_N1L05
XXCBM2_1 XSWB2/D ua[1] tt_um_jlvsdlv_ecg_C30
XXI1bP XI1bP/G XI2bP/G VDPWR VDPWR tt_um_jlvsdlv_ecg_P2L05
XXCPF1 ua[2] ua[0] tt_um_jlvsdlv_ecg_C2025
XXCBM2_2 XSWB2/D ua[1] tt_um_jlvsdlv_ecg_C30
XXI1aP XI1aP/G XI2aP/G VDPWR VDPWR tt_um_jlvsdlv_ecg_P2L05
XXCPF2 ua[3] ua[1] tt_um_jlvsdlv_ecg_C2025
XXM4B_0 XMR4/D ua[2] XMCLb/B VGND tt_um_jlvsdlv_ecg_M34S
XXCBM2_3 XSWB2/D ua[1] tt_um_jlvsdlv_ecg_C30
XXA1 XA1/G XPB/G VGND XS1/D tt_um_jlvsdlv_ecg_NL2L4
XXM4B_1 XMR4/D ua[2] XMCLb/B VGND tt_um_jlvsdlv_ecg_M34S
XXCBM2_4 XSWB2/D ua[1] tt_um_jlvsdlv_ecg_C30
XXPA XPB/G XPB/G ua[5] ua[5] tt_um_jlvsdlv_ecg_PL4L2
XXA2 XA2/G XPB/D VGND XS1/D tt_um_jlvsdlv_ecg_NL2L4
XXSCT2_0 ui_in[0] XSCT2_0/D VGND VGND tt_um_jlvsdlv_ecg_N1L05
XXPB XPB/G XPB/D ua[5] ua[5] tt_um_jlvsdlv_ecg_PL4L2
XXCBC1_0 XSWB1/D XSWB1/D XSWB1/D ua[0] ua[0] ua[0] XSWB1/D XSWB1/D ua[0] ua[0] XSWB1/D
+ ua[0] XSWB1/D ua[0] ua[0] ua[0] XSWB1/D XSWB1/D VGND tt_um_jlvsdlv_ecg_VAR9G
XXSCT2_1 ui_in[1] XSCT2_1/D VGND VGND tt_um_jlvsdlv_ecg_N1L05
XXCBC1_1 XSWB1/D XSWB1/D XSWB1/D ua[0] ua[0] ua[0] XSWB1/D XSWB1/D ua[0] ua[0] XSWB1/D
+ ua[0] XSWB1/D ua[0] ua[0] ua[0] XSWB1/D XSWB1/D VGND tt_um_jlvsdlv_ecg_VAR9G
XXSCT2_2 ui_in[2] XSCT2_2/D VGND VGND tt_um_jlvsdlv_ecg_N1L05
XXCBC1_2 XSWB1/D XSWB1/D XSWB1/D ua[0] ua[0] ua[0] XSWB1/D XSWB1/D ua[0] ua[0] XSWB1/D
+ ua[0] XSWB1/D ua[0] ua[0] ua[0] XSWB1/D XSWB1/D VGND tt_um_jlvsdlv_ecg_VAR9G
XXSCT2_3 ui_in[3] XSCT2_3/D VGND VGND tt_um_jlvsdlv_ecg_N1L05
XXCT2_9a ua[1] XSCT2_9/D tt_um_jlvsdlv_ecg_C245
XXCG_0 XMR3/D XMR4/D tt_um_jlvsdlv_ecg_C30
XXNDAbP1 XIKCP/D XI1bP/G VDPWR VDPWR tt_um_jlvsdlv_ecg_P1L05
XXMREP XMREP/G XMREP/G XA1/G XMREP/G XA1/G XMREP/G XMREP/G XA1/G XMREP/G XA1/G XMREP/G
+ XA1/G XMREP/G XA1/G XMREP/G XA1/G XA1/G XA1/G XA1/G XA1/G XA1/G XA1/G XA1/G XA1/G
+ XA1/G XA1/G XMREP/G XMREP/G XMREP/G XMREP/G XMREP/G XMREP/G XA1/G XA1/G XMREP/G
+ XMREP/G XA1/G XMREP/G XMREP/G XMREP/G XA1/G XMREP/G XMREP/G XMREP/G XMREP/G XA1/G
+ XA1/G XA1/G XMREP/G XA1/G XMREP/G tt_um_jlvsdlv_ecg_MREP
XXSCT2_4 ui_in[4] XSCT2_4/D VGND VGND tt_um_jlvsdlv_ecg_N1L05
XXCCB_0 XI2bP/D XMCLb/B tt_um_jlvsdlv_ecg_C30
XXCCM_0 XPB/D ua[4] tt_um_jlvsdlv_ecg_C30
XXCT2_9b ua[1] XSCT2_9/D tt_um_jlvsdlv_ecg_C245
XXCG_1 XMR4/D XMR3/D tt_um_jlvsdlv_ecg_C30
XXNDAbP2 uio_in[2] XI1bP/G VDPWR VDPWR tt_um_jlvsdlv_ecg_P1L05
XXCT1_0 XSCT1_0/D ua[0] VGND tt_um_jlvsdlv_ecg_VB0G
XXCCB_1 XI2bP/D XMCLb/B tt_um_jlvsdlv_ecg_C30
XXSCT2_5 ui_in[5] XSCT2_5/D VGND VGND tt_um_jlvsdlv_ecg_N1L05
XXM1_3L ua[0] XSWB1/D ua[3] ua[3] ua[3] XA1/G XA1/G tt_um_jlvsdlv_ecg_XP1B
XXCCM_1 XPB/D ua[4] tt_um_jlvsdlv_ecg_C30
XXCG_2 XMR3/D XMR4/D tt_um_jlvsdlv_ecg_C30
XXM3A_0 XMR3/D ua[3] XMCLa/B VGND tt_um_jlvsdlv_ecg_M34S
XXNDAbN1 XIKCP/D XI1bP/G VGND XNDAbN2/D tt_um_jlvsdlv_ecg_N1L05
XXCT1_1 ua[0] ua[0] XSCT1_1/D XSCT1_1/D VGND tt_um_jlvsdlv_ecg_VB1G
XXM1_2L ua[0] XSWB1/D ua[3] ua[3] ua[3] XA1/G XA1/G tt_um_jlvsdlv_ecg_XP1B
XXSCT2_6 ui_in[6] XSCT2_6/D VGND VGND tt_um_jlvsdlv_ecg_N1L05
XXCCB_2 XI2bP/D XMCLb/B tt_um_jlvsdlv_ecg_C30
XXCCM_2 XPB/D ua[4] tt_um_jlvsdlv_ecg_C30
XXCF3 ua[3] XMR3/D tt_um_jlvsdlv_ecg_C236
XXM3A_1 XMR3/D ua[3] XMCLa/B VGND tt_um_jlvsdlv_ecg_M34S
XXCG_3 XMR4/D XMR3/D tt_um_jlvsdlv_ecg_C30
XXNDAbN2 uio_in[2] XNDAbN2/D VGND VGND tt_um_jlvsdlv_ecg_N1L05
XXCT1_2 ua[0] ua[0] ua[0] ua[0] XSCT1_2/D XSCT1_2/D XSCT1_2/D XSCT1_2/D VGND tt_um_jlvsdlv_ecg_VB2G
XXSCT2_7 ui_in[7] XSCT2_7/D VGND VGND tt_um_jlvsdlv_ecg_N1L05
XXM1_1L ua[0] XSWB1/D ua[3] ua[3] ua[3] XA1/G XA1/G tt_um_jlvsdlv_ecg_XP1B
XXCCM_3 XPB/D ua[4] tt_um_jlvsdlv_ecg_C30
XXCG_4 XMR3/D XMR4/D tt_um_jlvsdlv_ecg_C30
XXCF4 ua[2] XMR4/D tt_um_jlvsdlv_ecg_C236
XXCT1_3 ua[0] ua[0] ua[0] ua[0] ua[0] ua[0] ua[0] XSCT1_3/D XSCT1_3/D ua[0] XSCT1_3/D
+ XSCT1_3/D XSCT1_3/D XSCT1_3/D XSCT1_3/D XSCT1_3/D VGND tt_um_jlvsdlv_ecg_VB3G
XXSCT2_8 uio_in[0] XSCT2_8/D VGND VGND tt_um_jlvsdlv_ecg_N1L05
XXM1_0L ua[0] XSWB1/D ua[3] ua[3] ua[3] XA1/G XA1/G tt_um_jlvsdlv_ecg_XP1B
XXCCM_4 XPB/D ua[4] tt_um_jlvsdlv_ecg_C30
XXCG_5 XMR4/D XMR3/D tt_um_jlvsdlv_ecg_C30
XXIRSTN uio_in[3] XSWF4/G VGND VGND tt_um_jlvsdlv_ecg_N05L05
XXCT1_4 ua[0] XSCT1_4/D VGND tt_um_jlvsdlv_ecg_VB4G
XXSCT2_9 uio_in[1] XSCT2_9/D VGND VGND tt_um_jlvsdlv_ecg_N1L05
XXLD0 XA2/G XA2/G ua[5] ua[5] tt_um_jlvsdlv_ecg_MLAD
XXCG_6 XMR3/D XMR4/D tt_um_jlvsdlv_ecg_C30
XXCT1_5 XSCT1_5/D XSCT1_5/D ua[0] ua[0] VGND tt_um_jlvsdlv_ecg_VB5G
XXLD1 XLD2/S XLD2/S XA2/G XA2/G tt_um_jlvsdlv_ecg_MLAD
X0 VGND ui_in[4] sky130_fd_pr__diode_pw2nd_05v5 perim=2.4e+06 area=3.6e+11
X1 VGND uio_in[4] sky130_fd_pr__diode_pw2nd_05v5 perim=2.4e+06 area=3.6e+11
X2 VGND ui_in[5] sky130_fd_pr__diode_pw2nd_05v5 perim=2.4e+06 area=3.6e+11
X3 VGND uio_in[1] sky130_fd_pr__diode_pw2nd_05v5 perim=2.4e+06 area=3.6e+11
.ends
