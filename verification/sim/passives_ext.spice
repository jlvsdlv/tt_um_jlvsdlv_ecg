* simple models for passives in the magic-extracted netlist (values as used in the v5 schematic sims)
.subckt sky130_fd_pr__cap_mim_m3_1 c0 c1 w=1 l=1 m=1
C1 c0 c1 {m*(2.0e-15*w*l + 0.19e-15*2*(w+l))}
.ends
.subckt sky130_fd_pr__res_xhigh_po_0p35 r0 r1 b l=5 mult=1
R1 r0 r1 {2000*l/0.35*(1 - 1.47e-3*(temper-27) + 2.7e-6*(temper-27)*(temper-27))/mult}
.ends
.subckt sky130_fd_pr__diode_pw2nd_05v5 a k area=1 perim=1
D1 a k dant
.model dant d is=1e-18 cjo=0.5e-15
.ends
